* Circuit1.CIR -simple circuit 1-
V1 N1 0 5
R1 N1 N2 11K
R2 N1 0 1K
R3 N2 N4 1K
R4 N4 0 1K
R5 N2 N4 1K
.op
.End
